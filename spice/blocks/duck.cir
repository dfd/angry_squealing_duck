* ---------------------------------------------------------------------------
* duck - the full Angry Squealing Duck signal path (pre-volume)
*
* Pins:  in out vref vp vn   params: squeal anger quack
*
*   in -> input buffer -> split -+- AUDIO:   fuzz(Anger) -> octave(Squeal) -> VCF
*                                |                                            ^
*                                +- CONTROL: envelope follower -> gc ---------+
*
* Octave-AFTER-fuzz (Fender Blender / Hoof Reaper pattern): rectifying the
* already-distorted signal yields a prominent "ring" octave, and Squeal blends
* plain-fuzz vs octave-fuzz independently of Anger.
*
* The VCF cutoff is driven by gc = max(cv - vref, 0), the ground-referenced
* envelope of the RAW split (pre-fuzz dynamics). out = band-pass tap (pre-volume).
* ---------------------------------------------------------------------------
.subckt duck in out vref vp vn params: squeal=1 anger=0.6 quack=1 muff=1 wlp=0 wbp=1 whp=0
* input buffer + split node 'sig'
Xib  in  sig vref vp vn input_buffer
* --- audio path: fuzz -> octave(blend) -> VCF ---
* fuzz select (muff=0 hard-clip, muff=1 Muff): feed only the chosen fuzz a live
* signal; the other sees vref (idles, no wasted convergence).
Bsh  sh 0 V = V(vref) + (1-muff)*(V(sig)-V(vref))
Bsm  sm 0 V = V(vref) + muff*(V(sig)-V(vref))
Xfzh sh  fzh vref vp vn fuzz      anger={anger}
Xfzm sm  fzm vref vp vn fuzz_muff anger={anger}
Bfz  fz 0 V = V(vref) + (1-muff)*(V(fzh)-V(vref)) + muff*(V(fzm)-V(vref))
Xoct fz  oc  vref vp vn octave_rect squeal={squeal}
Xvcf oc  out gc   vref vp vn vcf    quack={quack} wlp={wlp} wbp={wbp} whp={whp}
* --- control path: raw envelope -> ground-referenced cutoff control ---
* (2.2x sensitivity -> deeper, quackier sweep)
Xenv sig cv  vref vp vn envfollow
Bgc  gc  0   V = max(2.2*(V(cv)-V(vref)),0)
.ends duck
