* ---------------------------------------------------------------------------
* vcf - voltage-controlled state-variable band-pass (Q-Tron core, behavioral)
*
* Pins:  in out gc vref vp vn      params: quack=1
*   gc : GROUND-referenced cutoff control (>=0; 0 = parked). Generated from the
*        envelope by the integration stage (gc = max(cv - vref, 0)).
*
* Chamberlin state-variable loop, band-pass tap:
*   hp = in - lp - d*bp        (all relative to vref)
*   bp = (w0/s) hp             (gm-C integrator 1)
*   lp = (w0/s) bp             (gm-C integrator 2)
* -> bp/in = w0*s / (s^2 + d*w0*s + w0^2)   : band-pass, peak gain 1/d = Q at w0.
*
* Quack ganged control:
*   - sweep depth (drive): passed to the integrators (w0 swept by gc)
*   - resonance (Q):       d = 1.4 - 1.25*quack  ->  Q ~ 0.7 (CCW) up to ~6.7 (CW)
* So Quack CCW = parked, low-Q (effectively off); CW = deep resonant sweep.
* ---------------------------------------------------------------------------
.subckt vcf in out gc vref vp vn params: quack=1
* summer -> high-pass state (ideal summing node, referenced to vref)
Bhp hp vref V = (V(in)-V(vref)) - (V(lp)-V(vref)) - (1.4-1.25*quack)*(V(bp)-V(vref))
* two voltage-controlled integrators
Xi1 hp bp gc vref gmint quack={quack}
Xi2 bp lp gc vref gmint quack={quack}
* band-pass tap, buffered so downstream loads don't disturb the filter state
Xob bp out out vp vn opamp
.ends vcf
